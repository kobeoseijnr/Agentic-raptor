* Reference OTA testbench excerpt (smoke test netlist modality)
* circuit: ota
VDD vdd 0 DC 1.8
VCM vcm 0 DC 0.9
CL out 0 1p
* five-transistor core omitted; this file exercises netlist parsing only
.end
